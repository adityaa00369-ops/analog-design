* 1.8 V common-source amplifier a2
.include "tsmc081.lib"
.temp 27
VDD vdd 0 1.8
VIN in 0 SINE(0 2m 1k 0 0 90) AC 1
RG1 vdd gate 182k
RG2 gate 0 100k
RD vdd drain 1.4k
RS source 0 218
M1 drain gate source 0 CMOSN L=0.36u W=93.6u
CG in gate 123n
CS source 0 22.10u
CD drain out 1u
RL out 0 10k
*.op
.ac dec 200 1 1G
*.tran 0 100m 0 2u
.end
